spicesmith structural generator 1 seed 17
.param vsupply=1.2
.option reltol=1e-3 abstol=1e-13 vntol=1e-6 method=trap
.model n nmos level=54 version=4.8
.model p pmos level=54 version=4.8
.model diode d is=1e-14 n=1.05 rs=2 cjo=5f
Vd0 n3 0 1.2
Rd1 n3 n1 0.5
Rd2 n2 0 0.1
Cd3 n1 n2 1e-10
Rd4 n1 n4 0.5
Rd5 n5 n2 0.1
Cd6 n4 n5 1e-10
Vd7 n6 n5 SIN(0.6 0.05 11347427.9796 0 0 257.131856649)
Rd8 n6 n7 1210.41471896
Vd9 n8 n5 PULSE(0 1.2 8.92789707606e-08 4.41282813293e-09 4.41282813293e-09 1.10320703323e-07 2.20641406646e-07)
Md10 n9 n8 n5 n5 n l=2.07192764384e-07 w=9.53504985682e-07
Md11 n9 n8 n4 n4 p l=2.32946566488e-07 w=1.83433807914e-06
Id12 n4 n11 6.29838102224e-05
Md13 n11 n11 n5 n5 n l=5.18988022733e-07 w=3.75077460661e-07
Md14 n10 n11 n5 n5 n l=3.99316568029e-07 w=1.46902728444e-06
Vd15 n12 n5 0.6
Md16 n13 n7 n10 n5 n l=3.83677642628e-07 w=1.22719870634e-06
Md17 n14 n12 n10 n5 n l=4.01840190915e-07 w=4.19037911231e-07
Rd18 n4 n13 3695.18472353
Rd19 n4 n14 29374.0971705
Rd20 n13 n15 2940.7892544
Md21 n16 n15 n5 n5 n l=1.3e-07 w=1.97255839106e-07
Rd22 n4 n16 16769.472292
Cd23 n16 n5 7.11320653698e-13
Rd24 n16 n17 793.154323235
Md25 n18 n17 n5 n5 n l=1.48289726057e-07 w=1.18258106528e-06
Rd26 n4 n18 8303.13809077
Cd27 n18 n5 6.96808310692e-13
Rd28 n18 n19 1870.07859074
Md29 n20 n19 n5 n5 n l=2.01861756902e-07 w=5.58407712561e-07
Rd30 n4 n20 9225.81237591
Cd31 n20 n5 1.14467708975e-12
Cd32 n9 n7 3.29825363056e-13
Cd33 n9 n5 4.54283996563e-12
Rd34 n20 n5 168031.212819
Vd35 n21 n5 SIN(0.6 0.05 3110832.69009 0 0 121.791600943)
Rd36 n21 n22 398.401201709
Rd37 n20 n22 10000
Vd38 n23 n5 PULSE(0 1.2 5.53839956106e-08 3.00281848716e-09 3.00281848716e-09 7.5070462179e-08 1.50140924358e-07)
Md39 n24 n23 n5 n5 n l=1.93995358989e-07 w=9.64500947649e-07
Md40 n24 n23 n4 n4 p l=1.77408922224e-07 w=4.33779784619e-07
Md41 n25 n11 n5 n5 n l=2.17300636992e-07 w=8.58074036901e-07
Vd42 n26 n5 0.6
Md43 n27 n22 n25 n5 n l=1.87395872161e-07 w=5.33474327676e-07
Md44 n28 n26 n25 n5 n l=2.4411921811e-07 w=1.86539058175e-07
Rd45 n4 n27 29482.4206333
Rd46 n4 n28 19481.9782089
Rd47 n27 n29 729.353685237
Md48 n30 n29 n5 n5 n l=2.91462773658e-07 w=4.91189053689e-07
Rd49 n4 n30 10164.9546809
Cd50 n30 n5 6.17461218343e-13
Cd51 n24 n22 2.35089125711e-12
Cd52 n24 n5 1.35881426135e-11
Rd53 n30 n5 75062.9310541
Rd54 n1 0 1e+12
Rd55 n2 0 1e+12
Rd56 n3 0 1e+12
Rd57 n4 0 1e+12
Rd58 n5 0 1e+12
Rd59 n6 0 1e+12
Rd60 n7 0 1e+12
Rd61 n8 0 1e+12
Rd62 n9 0 1e+12
Rd63 n10 0 1e+12
Rd64 n11 0 1e+12
Rd65 n12 0 1e+12
Rd66 n13 0 1e+12
Rd67 n14 0 1e+12
Rd68 n15 0 1e+12
Rd69 n16 0 1e+12
Rd70 n17 0 1e+12
Rd71 n18 0 1e+12
Rd72 n19 0 1e+12
Rd73 n20 0 1e+12
Rd74 n21 0 1e+12
Rd75 n22 0 1e+12
Rd76 n23 0 1e+12
Rd77 n24 0 1e+12
Rd78 n25 0 1e+12
Rd79 n26 0 1e+12
Rd80 n27 0 1e+12
Rd81 n28 0 1e+12
Rd82 n29 0 1e+12
Rd83 n30 0 1e+12
.tran 2e-09 1e-06 0 2e-09
* spicesmith-output waveform.txt v(n1) v(n2) v(n20) v(n30)
.save v(n1) v(n2) v(n20) v(n30)
.end
